.title Single Neurotransistor

.SUBCKT MEMCAP TE BE SV

.param Ar=4.7447e-8 As=1.1253e-8 Br=2.6831 Bs=9.3348
.param c1=2.9457e-4 c2=57414 c3=11103 Rp=8e6 Rs=278 Cp=10p
.param wc=1000 xon=0.1 xoff=0.284

.func G(x,Vm) {Ar*x*exp(Br*sgn(Vm)*sqrt(abs(Vm)/x))+As*x*exp(-Bs*sgn(Vm)*sqrt(abs(Vm)))}
.func win_off(x) {-exp((x-xoff)*wc)}
.func win_on(x) {-exp(-(x-xon)*wc)}
.func F(Vm,x) {c1*(exp(c2*x*Vm*G(x,Vm)+win_off(x))-exp(-c3*x*Vm*G(x,Vm)+win_on(x)))}

Cx SV 0 1
Gx 0 SV value={F(V(IE,BE),V(SV,0))}
Gmem IE BE value={V(IE,BE)*G(V(SV,0),V(IE,BE))}
Rms TE IE {Rs}
Rmp IE BE {Rp}
Cmp TE BE {Cp}

.ENDS MEMCAP
.options reltol=1e-3 gmin=1e-12 method=gear
.ic v(sv0_0)=0.15 v(sv0_1)=0.1 v(sv0_2)=0.2 v(sv1_0)=0.1 v(sv1_1)=0.2 v(sv1_2)=0.2 v(sv2_0)=0.1 v(sv2_1)=0.1 v(sv2_2)=0.2 v(gate0)=0 v(gate1)=0 v(gate2)=0 v(rout_node)=0.8 v(vout_node)=0
VDD vdd 0 1.0
Vin1 in0 0 PWL(0s 0V 0.0s 0V 1e-07s 1.0V 2.9e-06s 1.0V 3e-06s 0V 3.3e-05s 0V 3.3100000000000005e-05s 1.0V 3.59e-05s 1.0V 3.6e-05s 0V 6.6e-05s 0V 6.610000000000001e-05s 1.0V 6.890000000000001e-05s 1.0V 6.900000000000001e-05s 0V 9.900000000000001e-05s 0V 9.910000000000001e-05s 1.0V 0.00010190000000000001s 1.0V 0.00010200000000000001s 0V 0.000132s 0V 0.0001321s 1.0V 0.0001349s 1.0V 0.000135s 0V 0.000165s 0V 0.0001651s 1.0V 0.0001679s 1.0V 0.000168s 0V 0.00019800000000000002s 0V 0.00019810000000000002s 1.0V 0.0002009s 1.0V 0.000201s 0V 0.00023100000000000003s 0V 0.00023110000000000003s 1.0V 0.00023390000000000002s 1.0V 0.00023400000000000002s 0V 0.000264s 0V 0.0002641s 1.0V 0.00026690000000000004s 1.0V 0.00026700000000000004s 0V 0.000297s 0V 0.0002971s 1.0V 0.0002999s 1.0V 0.00030000000000000003s 0V 0.00033s 0V 0.0003301s 1.0V 0.0003329s 1.0V 0.000333s 0V 0.00036300000000000004s 0V 0.00036310000000000004s 1.0V 0.00036590000000000006s 1.0V 0.00036600000000000006s 0V 0.00039600000000000003s 0V 0.00039610000000000003s 1.0V 0.00039890000000000005s 1.0V 0.00039900000000000005s 0V 0.000429s 0V 0.0004291s 1.0V 0.00043190000000000004s 1.0V 0.00043200000000000004s 0V 0.00046200000000000006s 0V 0.00046210000000000006s 1.0V 0.0004649000000000001s 1.0V 0.0004650000000000001s 0V 0.000495s 0V 0.0004950999999999999s 1.0V 0.0004979s 1.0V 0.000498s 0V 0.000528s 0V 0.0005281s 1.0V 0.0005309000000000001s 1.0V 0.000531s 0V 0.0005610000000000001s 0V 0.0005611s 1.0V 0.0005639000000000001s 1.0V 0.000564s 0V 0.000594s 0V 0.0005941s 1.0V 0.0005969s 1.0V 0.000597s 0V 0.0006270000000000001s 0V 0.0006271s 1.0V 0.0006299000000000001s 1.0V 0.00063s 0V 0.000660001s 0V 0.002s 0V)
Vin2 in1 0 PWL(0s 0V 9.9999e-05s 0V 0.0001s 0V 0.00010010000000000001s 1.0V 0.00010290000000000001s 1.0V 0.00010300000000000001s 0V 0.000133s 0V 0.0001331s 1.0V 0.0001359s 1.0V 0.000136s 0V 0.00016600000000000002s 0V 0.00016610000000000003s 1.0V 0.0001689s 1.0V 0.00016900000000000002s 0V 0.000199s 0V 0.00019910000000000001s 1.0V 0.0002019s 1.0V 0.000202s 0V 0.000232s 0V 0.0002321s 1.0V 0.0002349s 1.0V 0.000235s 0V 0.000265s 0V 0.0002651s 1.0V 0.0002679s 1.0V 0.000268s 0V 0.00029800000000000003s 0V 0.00029810000000000004s 1.0V 0.00030090000000000005s 1.0V 0.00030100000000000005s 0V 0.000331s 0V 0.0003311s 1.0V 0.00033390000000000004s 1.0V 0.00033400000000000004s 0V 0.000364s 0V 0.0003641s 1.0V 0.00036690000000000003s 1.0V 0.00036700000000000003s 0V 0.000397s 0V 0.0003971s 1.0V 0.0003999s 1.0V 0.0004s 0V 0.00043s 0V 0.0004301s 1.0V 0.0004329s 1.0V 0.000433s 0V 0.00046300000000000003s 0V 0.00046310000000000004s 1.0V 0.00046590000000000005s 1.0V 0.00046600000000000005s 0V 0.000496s 0V 0.0004961s 1.0V 0.0004989s 1.0V 0.000499s 0V 0.0005290000000000001s 0V 0.0005291s 1.0V 0.0005319000000000001s 1.0V 0.000532s 0V 0.0005620000000000001s 0V 0.0005621000000000001s 1.0V 0.0005649000000000001s 1.0V 0.0005650000000000001s 0V 0.000595s 0V 0.0005951s 1.0V 0.0005979000000000001s 1.0V 0.000598s 0V 0.0006280000000000001s 0V 0.0006281s 1.0V 0.0006309000000000001s 1.0V 0.000631s 0V 0.0006610000000000001s 0V 0.0006611000000000001s 1.0V 0.0006639000000000001s 1.0V 0.0006640000000000001s 0V 0.0006940000000000001s 0V 0.0006941s 1.0V 0.0006969000000000001s 1.0V 0.000697s 0V 0.0007270000000000001s 0V 0.0007271000000000001s 1.0V 0.0007299000000000001s 1.0V 0.0007300000000000001s 0V 0.0007600010000000001s 0V 0.002s 0V)
Vin3 in2 0 PWL(0s 0V 0.00019999900000000002s 0V 0.0002s 0V 0.0002001s 1.0V 0.0002029s 1.0V 0.000203s 0V 0.00023300000000000003s 0V 0.00023310000000000003s 1.0V 0.00023590000000000001s 1.0V 0.00023600000000000002s 0V 0.000266s 0V 0.0002661s 1.0V 0.00026890000000000003s 1.0V 0.00026900000000000003s 0V 0.000299s 0V 0.0002991s 1.0V 0.0003019s 1.0V 0.000302s 0V 0.00033200000000000005s 0V 0.00033210000000000005s 1.0V 0.00033490000000000006s 1.0V 0.00033500000000000007s 0V 0.000365s 0V 0.0003651s 1.0V 0.0003679s 1.0V 0.000368s 0V 0.000398s 0V 0.00039810000000000003s 1.0V 0.00040090000000000004s 1.0V 0.00040100000000000004s 0V 0.00043100000000000007s 0V 0.00043110000000000007s 1.0V 0.0004339000000000001s 1.0V 0.0004340000000000001s 0V 0.000464s 0V 0.0004641s 1.0V 0.0004669s 1.0V 0.000467s 0V 0.000497s 0V 0.0004971s 1.0V 0.0004999000000000001s 1.0V 0.0005s 0V 0.00053s 0V 0.0005300999999999999s 1.0V 0.0005329s 1.0V 0.0005329999999999999s 0V 0.000563s 0V 0.0005631s 1.0V 0.0005659s 1.0V 0.000566s 0V 0.0005960000000000001s 0V 0.0005961s 1.0V 0.0005989000000000001s 1.0V 0.000599s 0V 0.000629s 0V 0.0006291s 1.0V 0.0006319s 1.0V 0.000632s 0V 0.000662s 0V 0.0006621s 1.0V 0.0006649000000000001s 1.0V 0.000665s 0V 0.000695s 0V 0.0006950999999999999s 1.0V 0.0006979s 1.0V 0.0006979999999999999s 0V 0.000728s 0V 0.0007281s 1.0V 0.0007309s 1.0V 0.000731s 0V 0.0007610000000000001s 0V 0.0007611s 1.0V 0.0007639000000000001s 1.0V 0.000764s 0V 0.000794s 0V 0.0007941s 1.0V 0.0007969s 1.0V 0.000797s 0V 0.000827s 0V 0.0008271s 1.0V 0.0008299000000000001s 1.0V 0.00083s 0V 0.000860001s 0V 0.002s 0V)
XU1 in0 gate0 sv0_0 MEMCAP
XU2 in0 gate1 sv0_1 MEMCAP
XU3 in0 gate2 sv0_2 MEMCAP
XU4 in1 gate0 sv1_0 MEMCAP
XU5 in1 gate1 sv1_1 MEMCAP
XU6 in1 gate2 sv1_2 MEMCAP
XU7 in2 gate0 sv2_0 MEMCAP
XU8 in2 gate1 sv2_1 MEMCAP
XU9 in2 gate2 sv2_2 MEMCAP
CCs0 gate0 src0 5e-11
CCj0 drn0 0 5e-12
MM1 drn0 gate0 src0 0 NMOS
RRsrc src0 0 0.001
CCs1 gate1 src1 5e-11
CCj1 drn1 0 5e-12
MM2 drn1 gate1 src1 0 NMOS
RRt1 drn0 src1 1
CCs2 gate2 src2 5e-11
CCj2 drn2 0 5e-12
MM3 drn2 gate2 src2 0 NMOS
RRt2 drn1 src2 1
RRout drn2 rout_node 1
MM5 rout_node rout_node vdd vdd PMOS
MM4 vout_node rout_node vdd vdd PMOS
RRload vout_node 0 1000000.0
.model NMOS nmos (Kp=9.417436363636364e-05 L=2.6e-05 LEVEL=1 Tox=2.2e-08 Vto=0.2 W=9.4e-05)
.model PMOS pmos (Kp=3.139145454545455e-05 L=2.6e-05 LEVEL=1 Tox=2.2e-08 Vto=-0.2 W=9.4e-05)
